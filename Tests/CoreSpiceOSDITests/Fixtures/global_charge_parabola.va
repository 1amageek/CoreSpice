// Analytic verification fixture; follows the CoreSpice repository license.
`include "disciplines.vams"
module global_charge_parabola(inout p, q);
electrical p, q;
analog begin
    I(p) <+ ddt(V(p));
    I(q) <+ ddt(V(p)*V(p));
end
endmodule
