`include "dc_disciplines.vams"
module dynamic_latch(d, q);
    inout d, q;
    electrical d, q;
    integer state;
    analog begin
        @(cross(V(d) - 0.7, +1)) if (V(d) > 0.7) state = 1;
        @(cross(V(d) - 0.3, -1)) if (V(d) < 0.3) state = 0;
        I(q) <+ V(q) - state;
    end
endmodule
