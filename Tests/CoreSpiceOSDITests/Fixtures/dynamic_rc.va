`include "dc_disciplines.vams"
module dynamic_rc(p, n);
    inout p, n;
    electrical p, n;
    parameter real g = 0.001;
    parameter real c = 1.0e-9;
    parameter real q3 = 0.0;
    parameter real sw = 4.0e-24;
    parameter real sf = 6.0e-22;
    analog begin
        I(p, n) <+ g * V(p, n);
        I(p, n) <+ ddt(c * V(p, n) + q3 * V(p, n) * V(p, n) * V(p, n));
        I(p, n) <+ white_noise(sw, "white");
        I(p, n) <+ flicker_noise(sf, 1.0, "flicker");
    end
endmodule
