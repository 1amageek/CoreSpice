Native BSIM3 production analysis oracle pmos-qs
.model process pmos level=49 version=3.3.0 vth0=-0.7 u0=500 tox=10n
+ capmod=3 cj=1m cjsw=0.1n cgdo=0.2n cgso=0.3n rsh=20 acnqsmod=0 nlx=1.74e-07 elm=5417564028232.615
VD d 0 -1
VG g 0 sin(-1.2 -0.03 100Meg) ac -1
VS s 0 0
VB b 0 0.1
M1 d g s b process w=10u l=1u ad=2p as=3p pd=12u ps=14u nqsmod=0
.options gmin=1e-12 reltol=1e-7 abstol=1e-15
.control
set numdgt=17
set wr_singlescale
set wr_vecnames
ac lin 1 100Meg 100Meg
wrdata ac.dat i(vd) i(vg)
tran 2p 2n
linearize i(vd) i(vg)
wrdata tran.dat i(vd) i(vg)
quit
.endc
.end
